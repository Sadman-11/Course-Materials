* G:\My Drive\1EWU\Course Content\CSE251\CSE251 Lab Manual\PSpice\Q1.sch

* Schematics Version 9.1 - Web Update 1
* Thu Sep 11 12:06:54 2025

** Analysis setup **
.OP

* From [PSPICE NETLIST] section of pspiceev.ini:
.lib "nom.lib"

.INC "Q1.net"
.INC "Q1.als"

.probe

.END

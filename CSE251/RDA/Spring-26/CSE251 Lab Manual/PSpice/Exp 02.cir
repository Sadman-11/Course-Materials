* G:\My Drive\1EWU\Course Content\CSE251\CSE251 Shared\CSE251 Lab Manual\PSpice\Exp 02.sch

* Schematics Version 9.1 - Web Update 1
* Wed Apr 22 09:16:10 2026

** Analysis setup **
.tran 0ns 10ms
.OP

* From [PSPICE NETLIST] section of pspiceev.ini:
.lib "nom.lib"

.INC "Exp 02.net"
.INC "Exp 02.als"

.probe

.END
